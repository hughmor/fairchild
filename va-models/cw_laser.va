// CW laser source — injects a constant complex SVEA field.
//
// Signal representation: two optical ports per channel.
//   out_re: Re(A), out_im: Im(A)  — complex envelope in sqrt(W)
//
// Implementation: Norton-equivalent current source with large conductance G_src.
// This avoids potential contributions (which add internal branch nodes in OSDI).
// Converges to V(out_re) = A*cos(phi) and V(out_im) = A*sin(phi).
//
// Parameters:
//   power_mW     — output power in mW
//   phi_0_deg    — initial phase offset in degrees
//   wavelength_nm — carrier wavelength (nm) — sets omega_0 in SimContext

`include "disciplines.vams"
`include "constants.vams"
`include "disciplines/optical.vams"

module cw_laser(out_re, out_im);
    inout out_re, out_im;
    optical out_re, out_im;

    parameter real power_mW      = 1.0   from (0:inf);
    parameter real phi_0_deg     = 0.0;
    parameter real wavelength_nm = 1550.0 from (0:inf);

    real A_re, A_im, G_src;

    analog begin
        G_src = 1.0e6;  // Norton source conductance (S)
        A_re = sqrt(power_mW * 1e-3) * cos(phi_0_deg * `M_PI / 180.0);
        A_im = sqrt(power_mW * 1e-3) * sin(phi_0_deg * `M_PI / 180.0);

        // Norton equivalent: I = G*(A_target - V) → V converges to A_target.
        // Flow contribution: stamps I and -G*V (via the Ophase read).
        Oamp(out_re) <+ G_src * (A_re - Ophase(out_re));
        Oamp(out_im) <+ G_src * (A_im - Ophase(out_im));
    end
endmodule
