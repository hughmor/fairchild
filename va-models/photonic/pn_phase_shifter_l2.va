// PN junction phase shifter — Level 2 (Soref–Bennett plasma dispersion,
//                                       Shockley I–V, depletion capacitance)
//
// Improves on L1 in three ways:
//
//   1. Nonlinear plasma dispersion (Soref & Bennett 1987, Si at 1550 nm):
//        Δn  = −8.8e-22·ΔN − 8.5e-18·ΔP^0.8
//        Δα_fc = 8.5e-18·ΔN + 6.0e-18·ΔP          (cm⁻¹)
//      Carrier modulation (depletion regime):
//        ΔN(V) = n_dep0 · (1 − sqrt(max(1−V/Vbi, 0)))
//      ΔN = ΔP (equal electrons and holes depleted from p–n junction boundary)
//
//   2. Shockley diode I–V for the electrical port:
//        I_diode = IS · (exp(V_pn/(n_id·Vt)) − 1)
//
//   3. Bias-dependent depletion capacitance:
//        Cj(V) = Cj0 / (1 − V_cj/Vbi)^mj
//        I_cap = ddt(Cj·V_pn)                (reactive current)
//
// Optical output: same rotation/attenuation as L1 but with nonlinear Δφ and
// additional free-carrier absorption loss.
//
// Ports: (in_re,in_im,in_lambda) optical in, (out_re,out_im,out_lambda) optical out,
//        anode + cathode electrical.
//
// Parameters:
//   L_um        — PN-doped length (µm)
//   n_g         — group index
//   alpha_dB_cm — intrinsic waveguide loss (dB/cm), before FCA
//   n_dep0      — free-carrier density modulated at V_pn = 0 (cm⁻³)
//                 Typical Si carrier-depletion: 1e16–1e18 cm⁻³
//   Vbi         — built-in potential (V); Si p+n: 0.9–1.1 V
//   mj          — junction grading; abrupt=0.5
//   Cj0         — zero-bias capacitance (F); depends on junction area
//   IS          — diode saturation current (A)
//   n_id        — ideality factor (1–2)
//   wavelength_nm — design wavelength (nm); NR bootstrap

`include "disciplines.vams"
`include "constants.vams"
`include "disciplines/optical.vams"

module pn_phase_shifter_l2(in_re, in_im, in_lambda,
                            out_re, out_im, out_lambda,
                            anode, cathode);
    inout in_re, in_im, in_lambda;
    inout out_re, out_im, out_lambda;
    inout anode, cathode;
    optical    in_re, in_im, in_lambda, out_re, out_im, out_lambda;
    electrical anode, cathode;

    parameter real L_um         = 100.0   from (0:inf);
    parameter real n_g          = 4.2     from (0:inf);
    parameter real alpha_dB_cm  = 2.0     from [0:inf);  // intrinsic (pre-FCA)
    parameter real n_dep0       = 1e17    from (0:inf);  // cm⁻³ at V=0
    parameter real Vbi          = 1.0     from (0:inf);  // V
    parameter real mj           = 0.5     from (0:1];
    parameter real Cj0          = 20e-15  from (0:inf);  // F
    parameter real IS           = 1e-14   from (0:inf);  // A
    parameter real n_id         = 1.5;
    parameter real wavelength_nm = 1550.0 from (0:inf);

    real wl_nm, V_pn, V_cj, dN, dn_opt, dalpha_fc;
    real phi_prop, dphi, phi_total, alpha_lin, alpha_total;
    real T_amp, G_drv, Cj;
    real E_in_re, E_in_im, E_out_re, E_out_im;
    real Vt, tmp;

    analog begin
        G_drv = 1.0e6;
        Vt    = `P_K * 300.0 / `P_Q;   // thermal voltage at 300 K ≈ 25.85 mV

        wl_nm = Ophase(in_lambda) * 1e3;
        if (wl_nm < wavelength_nm * 0.99) wl_nm = wavelength_nm;

        phi_prop = 2.0 * `M_PI * n_g * (L_um * 1e-6) / (wl_nm * 1e-9);

        V_pn = V(anode, cathode);

        // Carrier density modulation (depletion regime)
        // ΔN > 0 when V < 0 (reverse bias depletes more carriers)
        tmp = 1.0 - V_pn / Vbi;
        if (tmp < 0.0) tmp = 0.0;
        dN = n_dep0 * (1.0 - sqrt(tmp));   // cm⁻³ depleted relative to V=0

        // Soref–Bennett plasma dispersion (Si, 1550 nm)
        // Sign: depletion removes carriers → Δn < 0 → blue-shifts resonance
        dn_opt    = -8.8e-22 * dN - 8.5e-18 * (dN >= 0.0 ? pow(dN, 0.8) : -pow(-dN, 0.8));   // RIU
        dalpha_fc = (8.5e-18 + 6.0e-18) * dN;                  // cm⁻¹

        dphi = 2.0 * `M_PI * dn_opt * (L_um * 1e-6) / (wl_nm * 1e-9);

        phi_total = phi_prop + dphi;

        // Total amplitude loss: intrinsic + FCA
        alpha_lin   = alpha_dB_cm * 1e2 / 8.685889;            // Np/m (intrinsic)
        alpha_total = alpha_lin + dalpha_fc * 1e2;              // Np/m (total)
        T_amp = exp(-alpha_total * (L_um * 1e-6) / 2.0);

        E_in_re = Ophase(in_re);
        E_in_im = Ophase(in_im);

        E_out_re = T_amp * ( E_in_re * cos(phi_total) + E_in_im * sin(phi_total));
        E_out_im = T_amp * (-E_in_re * sin(phi_total) + E_in_im * cos(phi_total));

        Oamp(out_re) <+ G_drv * (E_out_re - Ophase(out_re));
        Oamp(out_im) <+ G_drv * (E_out_im - Ophase(out_im));

        Oamp(in_re)     <+ 1e-12 * (-Ophase(in_re));
        Oamp(in_im)     <+ 1e-12 * (-Ophase(in_im));
        Oamp(in_lambda) <+ 1e-12 * (-Ophase(in_lambda));

        Oamp(out_lambda) <+ G_drv * (Ophase(in_lambda) - Ophase(out_lambda));

        // PN junction I–V: Shockley diode
        I(anode, cathode) <+ IS * (exp(V_pn / (n_id * Vt)) - 1.0);

        // Depletion capacitance (clamped)
        V_cj = V_pn;
        if (V_cj > 0.99 * Vbi) V_cj = 0.99 * Vbi;
        Cj = Cj0 / pow(1.0 - V_cj / Vbi, mj);
        I(anode, cathode) <+ ddt(Cj * V_pn);
    end
endmodule
