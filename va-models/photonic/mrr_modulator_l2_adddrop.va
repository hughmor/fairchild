// MRR electro-optic modulator — Level 2, Add-Drop configuration
//                              (Soref–Bennett plasma dispersion, Shockley I–V,
//                               depletion Cj, free-carrier absorption loss)
//
// Extends mrr_modulator_l1_adddrop with full PN junction physics.  The carrier
// depletion under reverse bias modifies both the ring refractive index and the
// round-trip loss via free-carrier absorption (FCA).
//
// Carrier depletion model (Soref–Bennett, Si at 1550 nm):
//
//   ΔN(V)      = n_dep0 · (1 − sqrt(max(1 − V/Vbi, 0)))   [cm⁻³]
//   Δn_opt(ΔN) = −8.8e-22·ΔN − 8.5e-18·ΔN^0.8            [RIU]
//   Δα_fc(ΔN)  = (8.5e-18 + 6.0e-18) · ΔN                 [cm⁻¹]
//
//   Δφ_PN = 2π·Δn_opt·L_ring / λ                           [rad, full round-trip]
//
// The FCA loss is added to the waveguide attenuation before computing a_half.
// This captures the intensity-dependent loss at high carrier densities (e.g.,
// under strong forward bias or high doping).
//
// Electrical port (L2):
//   I_diode = IS · (exp(V_pn/(n_id·Vt)) − 1)
//   I_cap   = ddt(Cj(V_pn) · V_pn)    where Cj = Cj0 / (1 − V_cj/Vbi)^mj
//
// The add-drop CMT transfer matrix (T11, T12, T22) is identical in structure
// to mrr_modulator_l1_adddrop; only α_total and Δφ_PN differ.
//
// Ports:
//   in_re, in_im, in_lambda         — input bus (3-wire optical)
//   th_re, th_im, th_lambda         — through port (3-wire optical)
//   dp_re, dp_im, dp_lambda         — drop port (3-wire optical)
//   ad_re, ad_im, ad_lambda         — add port (3-wire optical, input)
//   anode, cathode                  — PN junction (electrical)
//
// Parameters:
//   kappa_1, kappa_2 — power coupling coefficients for input/through and drop/add
//   L_ring_um        — ring circumference (µm)
//   n_g              — group index
//   alpha_dB_cm      — waveguide propagation loss (dB/cm), excluding FCA
//   n_dep0           — background free-carrier density at V=0 (cm⁻³)
//   Vbi              — built-in potential (V)
//   mj               — junction grading coefficient (0.5 = abrupt)
//   Cj0              — zero-bias junction capacitance (F)
//   IS               — diode saturation current (A)
//   n_id             — ideality factor
//   wavelength_nm    — design wavelength (nm); NR bootstrap guard
//
// Usage example:
//   Xring  in_re in_im in_lam  th_re th_im th_lam  dp_re dp_im dp_lam
//          ad_re ad_im ad_lam  anode cathode
//          mrr_modulator_l2_adddrop
//          .param kappa_1=0.1 kappa_2=0.05 L_ring_um=100

`include "disciplines.vams"
`include "constants.vams"
`include "disciplines/optical.vams"

module mrr_modulator_l2_adddrop(in_re, in_im, in_lambda,
                                 th_re, th_im, th_lambda,
                                 dp_re, dp_im, dp_lambda,
                                 ad_re, ad_im, ad_lambda,
                                 anode, cathode);
    inout in_re, in_im, in_lambda;
    inout th_re, th_im, th_lambda;
    inout dp_re, dp_im, dp_lambda;
    inout ad_re, ad_im, ad_lambda;
    inout anode, cathode;
    optical    in_re, in_im, in_lambda;
    optical    th_re, th_im, th_lambda;
    optical    dp_re, dp_im, dp_lambda;
    optical    ad_re, ad_im, ad_lambda;
    electrical anode, cathode;

    parameter real kappa_1      = 0.1    from [0:1];
    parameter real kappa_2      = 0.1    from [0:1];
    parameter real L_ring_um    = 100.0  from (0:inf);
    parameter real n_g          = 4.2    from (0:inf);
    parameter real alpha_dB_cm  = 2.0    from [0:inf);
    parameter real n_dep0       = 5e16   from (0:inf);   // cm⁻³
    parameter real Vbi          = 1.0    from (0:inf);
    parameter real mj           = 0.5    from (0:1];
    parameter real Cj0          = 50e-15 from (0:inf);   // F
    parameter real IS           = 1e-14  from (0:inf);
    parameter real n_id         = 1.5;
    parameter real wavelength_nm = 1550.0 from (0:inf);

    real wl_nm, V_pn, V_cj, tmp, dN, dn_opt, dalpha_fc;
    real phi_rt, phi_half, dphi_pn, alpha_lin, alpha_total;
    real r1, t1, r2, t2, a_half;
    real c_half, s_half, c_rt, s_rt, a_rt;
    real denom_A, denom_B, denom_sq;
    real N11_re, N11_im, N12_re, N12_im, N22_re, N22_im;
    real T11_re, T11_im, T12_re, T12_im, T22_re, T22_im;
    real E_in_re, E_in_im, E_ad_re, E_ad_im;
    real E_th_re, E_th_im, E_dp_re, E_dp_im;
    real Cj, Vt, G_drv;

    analog begin
        G_drv = 1.0e6;
        Vt    = `P_K * 300.0 / `P_Q;

        wl_nm = Ophase(in_lambda) * 1e3;
        if (wl_nm < wavelength_nm * 0.99) wl_nm = wavelength_nm;

        // Coupler field coefficients
        r1 = sqrt(1.0 - kappa_1);
        t1 = sqrt(kappa_1);
        r2 = sqrt(1.0 - kappa_2);
        t2 = sqrt(kappa_2);

        // PN junction plasma dispersion (Soref–Bennett)
        V_pn = V(anode, cathode);
        tmp  = 1.0 - V_pn / Vbi;
        if (tmp < 0.0) tmp = 0.0;
        dN       = n_dep0 * (1.0 - sqrt(tmp));
        dn_opt   = -8.8e-22 * dN - 8.5e-18 * (dN >= 0.0 ? pow(dN, 0.8) : -pow(-dN, 0.8));
        dalpha_fc = (8.5e-18 + 6.0e-18) * dN;   // cm⁻¹

        // Full round-trip phase
        dphi_pn = 2.0 * `M_PI * dn_opt * (L_ring_um * 1e-6) / (wl_nm * 1e-9);
        phi_rt  = 2.0 * `M_PI * n_g * (L_ring_um * 1e-6) / (wl_nm * 1e-9) + dphi_pn;

        // Half round-trip field amplitude (including FCA loss)
        alpha_lin   = alpha_dB_cm * 1e2 / 8.685889;   // dB/cm → Np/m
        alpha_total = alpha_lin + dalpha_fc * 1e2;      // cm⁻¹ → Np/m, then add
        a_half      = exp(-alpha_total * (L_ring_um * 1e-6) / 2.0);
        phi_half    = phi_rt / 2.0;

        c_half = a_half * cos(phi_half);
        s_half = a_half * sin(phi_half);

        c_rt = c_half * c_half - s_half * s_half;
        s_rt = 2.0 * c_half * s_half;
        a_rt = a_half * a_half;

        // Denominator
        denom_A  = 1.0 - r1 * r2 * c_rt;
        denom_B  = r1 * r2 * s_rt;
        denom_sq = denom_A * denom_A + denom_B * denom_B;

        // Numerators
        N11_re = r1 - r2 * c_rt;      N11_im = -r2 * s_rt;
        N12_re = -t1 * t2 * c_half;   N12_im = -t1 * t2 * s_half;
        N22_re = r2 - r1 * c_rt;      N22_im = -r1 * s_rt;

        // Complex division: T = N * D_conj / |D|²
        // D = denom_A − j·denom_B  →  D_conj = denom_A + j·denom_B
        // Re{N/D} = (N_re·A − N_im·B) / |D|²
        // Im{N/D} = (N_im·A + N_re·B) / |D|²
        T11_re = (N11_re * denom_A - N11_im * denom_B) / denom_sq;
        T11_im = (N11_im * denom_A + N11_re * denom_B) / denom_sq;
        T12_re = (N12_re * denom_A - N12_im * denom_B) / denom_sq;
        T12_im = (N12_im * denom_A + N12_re * denom_B) / denom_sq;
        T22_re = (N22_re * denom_A - N22_im * denom_B) / denom_sq;
        T22_im = (N22_im * denom_A + N22_re * denom_B) / denom_sq;

        // Read input fields
        E_in_re = Ophase(in_re);
        E_in_im = Ophase(in_im);
        E_ad_re = Ophase(ad_re);
        E_ad_im = Ophase(ad_im);

        // Superposition
        E_th_re = T11_re * E_in_re - T11_im * E_in_im
                + T12_re * E_ad_re - T12_im * E_ad_im;
        E_th_im = T11_im * E_in_re + T11_re * E_in_im
                + T12_im * E_ad_re + T12_re * E_ad_im;

        E_dp_re = T12_re * E_in_re - T12_im * E_in_im
                + T22_re * E_ad_re - T22_im * E_ad_im;
        E_dp_im = T12_im * E_in_re + T12_re * E_in_im
                + T22_im * E_ad_re + T22_re * E_ad_im;

        // Norton drive for output ports
        Oamp(th_re) <+ G_drv * (E_th_re - Ophase(th_re));
        Oamp(th_im) <+ G_drv * (E_th_im - Ophase(th_im));
        Oamp(dp_re) <+ G_drv * (E_dp_re - Ophase(dp_re));
        Oamp(dp_im) <+ G_drv * (E_dp_im - Ophase(dp_im));

        // High-impedance shunts on input ports
        Oamp(in_re)     <+ 1e-12 * (-Ophase(in_re));
        Oamp(in_im)     <+ 1e-12 * (-Ophase(in_im));
        Oamp(in_lambda) <+ 1e-12 * (-Ophase(in_lambda));
        Oamp(ad_re)     <+ 1e-12 * (-Ophase(ad_re));
        Oamp(ad_im)     <+ 1e-12 * (-Ophase(ad_im));
        Oamp(ad_lambda) <+ 1e-12 * (-Ophase(ad_lambda));

        // Lambda: output ports follow input lambda
        Oamp(th_lambda) <+ G_drv * (Ophase(in_lambda) - Ophase(th_lambda));
        Oamp(dp_lambda) <+ G_drv * (Ophase(in_lambda) - Ophase(dp_lambda));

        // Shockley diode
        I(anode, cathode) <+ IS * (exp(V_pn / (n_id * Vt)) - 1.0);

        // Depletion capacitance (clamp to avoid sqrt of negative in Cj)
        V_cj = V_pn;
        if (V_cj > 0.99 * Vbi) V_cj = 0.99 * Vbi;
        Cj = Cj0 / pow(1.0 - V_cj / Vbi, mj);
        I(anode, cathode) <+ ddt(Cj * V_pn);
    end
endmodule
