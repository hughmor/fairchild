// Straight optical waveguide — propagation loss + phase shift.
//
// 3-wire port representation per optical end:
//   in_re, in_im, in_lambda  — input field and wavelength
//   out_re, out_im, out_lambda — output field and wavelength
//
// Signal-flow model (unidirectional): reads in_re/in_im (high-impedance),
// drives out_re/out_im via Norton-equivalent sources.
// Lambda ports are high-impedance; wavelength is read from Owl(in_lambda).
//
// Physics: A_out = A_in · exp(-α·L/2) · exp(-j·β·L)
//   β = 2π·n_g / λ   (rad/m)
//
// Parameters:
//   L_um          — waveguide length in micrometers
//   n_g           — group index
//   alpha_dB_cm   — propagation loss in dB/cm
//   wavelength_nm — design wavelength (nm); used as NR bootstrap when Owl < 1 nm

`include "disciplines.vams"
`include "constants.vams"
`include "disciplines/optical.vams"

module waveguide(in_re, in_im, in_lambda, out_re, out_im, out_lambda);
    inout in_re, in_im, in_lambda, out_re, out_im, out_lambda;
    optical in_re, in_im, in_lambda, out_re, out_im, out_lambda;

    parameter real L_um          = 100.0  from (0:inf);
    parameter real n_g           = 4.2    from (0:inf);
    parameter real alpha_dB_cm   = 2.0    from [0:inf);
    parameter real wavelength_nm = 1550.0 from (0:inf);

    real wl_nm, beta, phi_prop, alpha_lin, T_amp, G_drv;
    real target_re, target_im;

    analog begin
        G_drv = 1.0e6;

        // Read wavelength from lambda port (stored in µm).
        // Bootstrap guard: use the parameter until V_wl is within 1% of the target.
        // With VMAX=0.5, V_wl ramps 0→0.5→1.0→1.5→1.55 µm over ~4 NR iterations;
        // without this guard, intermediate values (500–1500 nm) cause wrong phase.
        wl_nm = Ophase(in_lambda) * 1e3;   // µm → nm
        if (wl_nm < wavelength_nm * 0.99) wl_nm = wavelength_nm;

        beta     = 2.0 * `M_PI * n_g / (wl_nm * 1e-9);
        phi_prop = beta * (L_um * 1e-6);

        alpha_lin = alpha_dB_cm * 1e2 / 8.6859;
        T_amp     = exp(-alpha_lin * (L_um * 1e-6) / 2.0);

        target_re = T_amp * ( Ophase(in_re) * cos(phi_prop) + Ophase(in_im) * sin(phi_prop));
        target_im = T_amp * (-Ophase(in_re) * sin(phi_prop) + Ophase(in_im) * cos(phi_prop));

        // Norton drive for output amplitude ports
        Oamp(out_re) <+ G_drv * (target_re - Ophase(out_re));
        Oamp(out_im) <+ G_drv * (target_im - Ophase(out_im));

        // Input amplitude: high-impedance shunt
        Oamp(in_re) <+ 1e-12 * (-Ophase(in_re));
        Oamp(in_im) <+ 1e-12 * (-Ophase(in_im));

        // Lambda: output follows input (stamps cancel on shared wl net)
        Oamp(out_lambda) <+ G_drv * (Ophase(in_lambda) - Ophase(out_lambda));

        // Input lambda: high-impedance shunt
        Oamp(in_lambda) <+ 1e-12 * (-Ophase(in_lambda));
    end
endmodule
