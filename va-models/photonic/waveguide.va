// Straight optical waveguide — propagation loss + phase shift.
//
// Signal-flow model (unidirectional): reads in_re/in_im (high-impedance),
// drives out_re/out_im via Norton-equivalent current sources.
//
// No potential contributions → no internal nodes in OSDI.
//
// Physics: A_out = A_in * exp(-alpha_lin * L / 2) * exp(-j * beta * L)
//   beta = 2*pi*n_g / lambda_nm * 1e9 (rad/m)
//   A_out_re = T * (A_in_re * cos(phi) + A_in_im * sin(phi))
//   A_out_im = T * (-A_in_re * sin(phi) + A_in_im * cos(phi))
//
// Parameters:
//   L_um         — waveguide length in micrometers
//   n_g          — group index
//   alpha_dB_cm  — propagation loss in dB/cm
//   wavelength_nm — design wavelength for beta calculation

`include "disciplines.vams"
`include "constants.vams"
`include "disciplines/optical.vams"

module waveguide(in_re, in_im, out_re, out_im);
    inout in_re, in_im, out_re, out_im;
    optical in_re, in_im, out_re, out_im;

    parameter real L_um          = 100.0  from (0:inf);
    parameter real n_g           = 4.2    from (0:inf);
    parameter real alpha_dB_cm   = 2.0    from [0:inf);
    parameter real wavelength_nm = 1550.0 from (0:inf);

    real beta, phi_prop, alpha_lin, T_amp, G_drv;
    real target_re, target_im;

    analog begin
        G_drv = 1.0e6;

        beta     = 2.0 * `M_PI * n_g / (wavelength_nm * 1e-9);
        phi_prop = beta * (L_um * 1e-6);

        alpha_lin = alpha_dB_cm * 1e2 / 8.6859;  // convert dB/cm → Np/m
        T_amp     = exp(-alpha_lin * (L_um * 1e-6) / 2.0);

        // Target output field (complex rotation + attenuation)
        target_re = T_amp * ( Ophase(in_re) * cos(phi_prop) + Ophase(in_im) * sin(phi_prop));
        target_im = T_amp * (-Ophase(in_re) * sin(phi_prop) + Ophase(in_im) * cos(phi_prop));

        // Norton drive: I = G*(target - V_out) → V_out converges to target
        Oamp(out_re) <+ G_drv * (target_re - Ophase(out_re));
        Oamp(out_im) <+ G_drv * (target_im - Ophase(out_im));

        // Input ports: high-impedance (tiny shunt ensures in nodes are in Jacobian)
        Oamp(in_re) <+ 1e-12 * (-Ophase(in_re));
        Oamp(in_im) <+ 1e-12 * (-Ophase(in_im));
    end
endmodule
