// Directional coupler — wavelength-dependent 2×2 evanescent coupler.
//
// Ports: two input complex field pairs, two output complex field pairs.
//   a1 = (a1_re, a1_im): input port 1  (through arm)
//   a2 = (a2_re, a2_im): input port 2  (cross arm)
//   b1 = (b1_re, b1_im): output port 1 (through)
//   b2 = (b2_re, b2_im): output port 2 (cross)
//
// Transfer matrix (lossless symmetric coupler):
//   b1 = sqrt(1-kappa) * a1 + j*sqrt(kappa) * a2
//   b2 = j*sqrt(kappa) * a1 + sqrt(1-kappa) * a2
//
// In real/imaginary:
//   b1_re =  sqrt(1-kappa)*a1_re - sqrt(kappa)*a2_im
//   b1_im =  sqrt(1-kappa)*a1_im + sqrt(kappa)*a2_re
//   b2_re = -sqrt(kappa)*a1_im   + sqrt(1-kappa)*a2_re
//   b2_im =  sqrt(kappa)*a1_re   + sqrt(1-kappa)*a2_im
//
// Parameters:
//   kappa_0       — power coupling ratio at lambda_0 [0, 1]
//   lambda_0_nm   — design wavelength for kappa_0
//   dcoupling_dlambda — d(kappa)/d(lambda) in 1/nm (wavelength sensitivity)
//   wavelength_nm — operating wavelength

`include "disciplines.vams"
`include "constants.vams"
`include "disciplines/optical.vams"

module directional_coupler(a1_re, a1_im, a2_re, a2_im, b1_re, b1_im, b2_re, b2_im);
    inout a1_re, a1_im, a2_re, a2_im;
    inout b1_re, b1_im, b2_re, b2_im;
    optical a1_re, a1_im, a2_re, a2_im;
    optical b1_re, b1_im, b2_re, b2_im;

    parameter real kappa_0            = 0.5   from [0:1];   // power coupling at lambda_0
    parameter real lambda_0_nm        = 1550.0 from (0:inf);
    parameter real dcoupling_dlambda  = 0.0;                // sensitivity (1/nm)
    parameter real wavelength_nm      = 1550.0 from (0:inf);

    real kappa, sq_t, sq_k;
    real a1r, a1i, a2r, a2i;

    analog begin
        // Wavelength-dependent coupling ratio (linear model, clamped to [0,1])
        kappa = kappa_0 + dcoupling_dlambda * (wavelength_nm - lambda_0_nm);
        if (kappa < 0.0) kappa = 0.0;
        if (kappa > 1.0) kappa = 1.0;

        sq_t = sqrt(1.0 - kappa);  // through amplitude coefficient
        sq_k = sqrt(kappa);        // cross amplitude coefficient (90° phase shift)

        a1r = Ophase(a1_re);  a1i = Ophase(a1_im);
        a2r = Ophase(a2_re);  a2i = Ophase(a2_im);

        // Drive output port fields
        Ophase(b1_re) <+ sq_t * a1r - sq_k * a2i;
        Ophase(b1_im) <+ sq_t * a1i + sq_k * a2r;
        Ophase(b2_re) <+ -sq_k * a1i + sq_t * a2r;
        Ophase(b2_im) <+  sq_k * a1r + sq_t * a2i;

        // Input ports are high-impedance
        Oamp(a1_re) <+ 0.0;  Oamp(a1_im) <+ 0.0;
        Oamp(a2_re) <+ 0.0;  Oamp(a2_im) <+ 0.0;
    end
endmodule
