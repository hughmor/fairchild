// va_prbs — maximal-length PRBS pattern generator.
//
// A bench pattern generator as a compact model: a Fibonacci LFSR clocked at
// `1/t_bit`, driving one terminal with a voltage. It exists so a link deck can
// carry its own stimulus instead of receiving a several-thousand-point `PWL`
// string built by whatever script wrote the netlist.
//
// Terminals:
//   out           pattern output, driven as a voltage against ground
//
// Parameters:
//   order         LFSR length, 7/9/11/15 (sequence is 2^order - 1 long)
//   t_bit         bit period (s)
//   v_lo, v_hi    output levels (V)
//   t_edge        10-90 transition time (s); 0 gives a hard step
//   seed          initial register value; must not be 0
//
// Taps are the standard maximal-length pairs:
//   7  -> x^7 + x^6 + 1        9  -> x^9 + x^5 + 1
//   11 -> x^11 + x^9 + 1       15 -> x^15 + x^14 + 1
//
// ─────────────────────────────────────────────────────────────────────────────
// NOT COMPILED OR TESTED. OpenVAF-Reloaded is not available in the environment
// this was written in, so this file has never been through `openvaf-r` and has
// never been run. It is the shape the model takes, not a verified model — treat
// it as a starting point, compile it with `./build.sh`, and check it against
// `examples/photonic/noisy_eye_and_ber.py`, which generates the identical
// sequence in Python (`prbs()`, same taps, same all-ones seed) and is what the
// committed results use.
//
// The part most likely to need work is the clocking. `$bound_step` keeps the
// integrator from stepping over a bit boundary, and the register advances on a
// `timer` event; OSDI's support for `timer` in an analog block is the thing to
// verify first. If it does not survive compilation, the fallback that certainly
// works is to drive the sequence from `$abstime` arithmetic with no state at
// all — index the bit as `floor($abstime/t_bit)` and recompute the LFSR from
// the seed each evaluation, which is O(n) per timepoint but has no events in it.
// ─────────────────────────────────────────────────────────────────────────────

`include "constants.vams"
`include "disciplines.vams"

module va_prbs(out);
    inout out;
    electrical out;

    parameter integer order = 9   from [7:15];
    parameter real t_bit  = 100p from (0:inf);
    parameter real v_lo   = 0.0;
    parameter real v_hi   = 1.0;
    parameter real t_edge = 0.0  from [0:inf);
    parameter integer seed = 511  from [1:inf);

    integer reg_state, tap_a, tap_b, fb, bit;
    real    v_now, v_prev, t_switch;

    analog begin
        @(initial_step) begin
            reg_state = seed;
            case (order)
                7:  begin tap_a = 7;  tap_b = 6;  end
                9:  begin tap_a = 9;  tap_b = 5;  end
                11: begin tap_a = 11; tap_b = 9;  end
                default: begin tap_a = 15; tap_b = 14; end
            endcase
            bit      = reg_state & 1;
            v_now    = bit ? v_hi : v_lo;
            v_prev   = v_now;
            t_switch = 0.0;
        end

        // Advance one bit per period. The register update is the whole reason
        // this is a stateful model rather than a function of $abstime.
        @(timer(t_bit, t_bit)) begin
            fb        = ((reg_state >> (tap_a - 1)) & 1) ^ ((reg_state >> (tap_b - 1)) & 1);
            reg_state = ((reg_state << 1) | fb) & ((1 << order) - 1);
            bit       = reg_state & 1;
            v_prev    = v_now;
            v_now     = bit ? v_hi : v_lo;
            t_switch  = $abstime;
        end

        // Linear ramp across t_edge, centred nowhere in particular: the edge
        // starts at the bit boundary. `noisy_eye_and_ber.py` centres its edges
        // on the boundary instead, which is what a real driver does; match that
        // if you care about where the eye crossing lands.
        if (t_edge > 0.0 && $abstime < t_switch + t_edge)
            V(out) <+ v_prev + (v_now - v_prev) * ($abstime - t_switch) / t_edge;
        else
            V(out) <+ v_now;

        // Do not let the integrator step over a bit boundary.
        $bound_step(t_bit / 8.0);
    end
endmodule
