// Two modules in one file, so one compiled library carries two descriptors.
//
// This is what a PDK's Verilog-A looks like, and it is the case a single-model
// fixture cannot check: descriptors are walked with the stride the *library*
// reports, not the size of our own struct, and the two differ in practice — the
// compiler's descriptor is larger than the prefix we read. Stride by the wrong
// one and the second model is read out of the middle of the first.
`include "disciplines.vams"

module first_g(a, b);
    inout a, b;
    electrical a, b;
    parameter real gd = 2e-3 from (0:inf);
    analog I(a, b) <+ gd * V(a, b);
endmodule

module second_g(a, b);
    inout a, b;
    electrical a, b;
    parameter real gd = 5e-3 from (0:inf);
    parameter real c = 1e-12 from [0:inf);
    analog begin
        I(a, b) <+ gd * V(a, b);
        I(a, b) <+ ddt(c * V(a, b));
    end
endmodule
