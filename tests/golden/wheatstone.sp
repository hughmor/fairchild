* Wheatstone bridge: balanced, so V(mid) = 0
* R1=R3=1k (left arm), R2=R4=1k (right arm)
* V(a) = V1/2, V(b) = V1/2 -> V(a)-V(b) = 0
V1 top 0 DC 10.0
R1 top a 1k
R2 top b 1k
R3 a 0 1k
R4 b 0 1k

.op
.end
