* Current divider: I1=1mA splits across R1=2k and R2=3k in parallel
* V(a) = I1 * (R1||R2) = 1e-3 * 1200 = 1.2 V
* I through R1 = V(a)/R1 = 0.6 mA, I through R2 = V(a)/R2 = 0.4 mA
I1 0 a DC 1m
R1 a 0 2k
R2 a 0 3k

.op
