* Voltage divider: V(mid) should be V1/2 = 0.5 V
V1 in 0 DC 1.0
R1 in mid 1k
R2 mid 0 1k

.op
.end
