// MRR electro-optic modulator — Level 1, Add-Drop configuration
//                              (CMT quasi-static, linear PN phase)
//
// Add-drop ring resonator with a PN junction embedded in the ring waveguide.
// Unlike the all-pass (single-bus) topology, the add-drop ring has TWO coupling
// regions: one between the input/through bus and the ring (kappa_1), and one
// between the drop/add bus and the ring (kappa_2).
//
// The four-port transfer matrix is derived from the coupled-mode theory (CMT)
// for a symmetric ring with the half round-trip field as the building block:
//
//   a_half = exp(−α·L/2)           half round-trip field amplitude
//   φ_half = π·n_g·L/λ + Δφ/2     half round-trip phase (rad)
//
// The full transfer functions (from input E_in and add E_ad to through E_th
// and drop E_dp) are given by complex matrix elements T11, T12, T22:
//
//   E_th = T11·E_in + T12·E_ad
//   E_dp = T12·E_in + T22·E_ad
//
// At critical coupling (r1·r2·a_rt = 1) and resonance (φ_rt = 2πN), the
// input power splits between through and drop ports according to κ1/κ2.
//
// Voltage-tuning via the PN junction shifts the resonance:
//   Δφ_PN = π·(V_pn − V_ref)/Vpi_rt   (L1 linear model; full round-trip phase)
//
// Ports:
//   in_re, in_im, in_lambda         — input bus (3-wire optical)
//   th_re, th_im, th_lambda         — through port on input bus (3-wire optical)
//   dp_re, dp_im, dp_lambda         — drop port on drop bus (3-wire optical)
//   ad_re, ad_im, ad_lambda         — add port on drop bus (3-wire optical, input)
//   anode, cathode                  — PN junction bias (electrical)
//
// Level hierarchy:
//   L1 (this file): linear Δφ(V), no PN I–V, no free-carrier loss
//   L2: Soref–Bennett plasma dispersion + Shockley I–V + depletion Cj + FCA
//   L3: TPA self-heating (T_node port) + photocarrier generation
//
// Parameters:
//   kappa_1     — input/through coupler power coupling coefficient (0–1)
//   kappa_2     — drop/add coupler power coupling coefficient (0–1)
//   L_ring_um   — ring circumference (µm)
//   n_g         — waveguide group index
//   alpha_dB_cm — propagation loss (dB/cm)
//   Vpi_rt      — voltage (V) for π full round-trip phase shift
//   V_ref       — PN junction voltage at which Δφ_PN = 0 (V)
//   wavelength_nm — design wavelength (nm); NR bootstrap guard
//
// Usage example:
//   Xring  in_re in_im in_lam  th_re th_im th_lam  dp_re dp_im dp_lam
//          ad_re ad_im ad_lam  anode cathode
//          mrr_modulator_l1_adddrop
//          .param kappa_1=0.1 kappa_2=0.1 L_ring_um=100 Vpi_rt=10 V_ref=-2

`include "disciplines.vams"
`include "constants.vams"
`include "disciplines/optical.vams"

module mrr_modulator_l1_adddrop(in_re, in_im, in_lambda,
                                 th_re, th_im, th_lambda,
                                 dp_re, dp_im, dp_lambda,
                                 ad_re, ad_im, ad_lambda,
                                 anode, cathode);
    inout in_re, in_im, in_lambda;
    inout th_re, th_im, th_lambda;
    inout dp_re, dp_im, dp_lambda;
    inout ad_re, ad_im, ad_lambda;
    inout anode, cathode;
    optical    in_re, in_im, in_lambda;
    optical    th_re, th_im, th_lambda;
    optical    dp_re, dp_im, dp_lambda;
    optical    ad_re, ad_im, ad_lambda;
    electrical anode, cathode;

    parameter real kappa_1      = 0.1    from [0:1];   // input/through coupler
    parameter real kappa_2      = 0.1    from [0:1];   // drop/add coupler
    parameter real L_ring_um    = 100.0  from (0:inf);
    parameter real n_g          = 4.2    from (0:inf);
    parameter real alpha_dB_cm  = 2.0    from [0:inf);
    parameter real Vpi_rt       = 10.0   from (0:inf);   // V; full round-trip π shift
    parameter real V_ref        = 0.0;
    parameter real wavelength_nm = 1550.0 from (0:inf);

    real wl_nm, phi_rt, phi_half, dphi_pn, alpha_lin;
    real r1, t1, r2, t2, a_half;
    real c_half, s_half, c_rt, s_rt, a_rt;
    real denom_A, denom_B, denom_sq;
    real N11_re, N11_im, N12_re, N12_im, N22_re, N22_im;
    real T11_re, T11_im, T12_re, T12_im, T22_re, T22_im;
    real E_in_re, E_in_im, E_ad_re, E_ad_im;
    real E_th_re, E_th_im, E_dp_re, E_dp_im;
    real V_pn, G_drv;

    analog begin
        G_drv = 1.0e6;

        wl_nm = Ophase(in_lambda) * 1e3;
        if (wl_nm < wavelength_nm * 0.99) wl_nm = wavelength_nm;

        // Coupler field coefficients
        r1 = sqrt(1.0 - kappa_1);
        t1 = sqrt(kappa_1);
        r2 = sqrt(1.0 - kappa_2);
        t2 = sqrt(kappa_2);

        // PN voltage → full round-trip phase shift (L1 linear)
        V_pn   = V(anode, cathode);
        dphi_pn = `M_PI * (V_pn - V_ref) / Vpi_rt;

        // Full round-trip phase (base propagation + PN shift)
        phi_rt = 2.0 * `M_PI * n_g * (L_ring_um * 1e-6) / (wl_nm * 1e-9) + dphi_pn;

        // Half round-trip quantities
        alpha_lin = alpha_dB_cm * 1e2 / 8.685889;   // dB/cm → Np/m
        a_half    = exp(-alpha_lin * (L_ring_um * 1e-6) / 2.0);
        phi_half  = phi_rt / 2.0;

        c_half = a_half * cos(phi_half);
        s_half = a_half * sin(phi_half);

        // Full round-trip products (double-angle identities)
        c_rt = c_half * c_half - s_half * s_half;   // a_rt * cos(phi_rt)
        s_rt = 2.0 * c_half * s_half;               // a_rt * sin(phi_rt)
        a_rt = a_half * a_half;

        // Denominator: D = 1 − r1·r2·(c_rt + j·s_rt)
        denom_A  = 1.0 - r1 * r2 * c_rt;
        denom_B  = r1 * r2 * s_rt;
        denom_sq = denom_A * denom_A + denom_B * denom_B;

        // Numerators
        N11_re = r1 - r2 * c_rt;      N11_im = -r2 * s_rt;
        N12_re = -t1 * t2 * c_half;   N12_im = -t1 * t2 * s_half;
        N22_re = r2 - r1 * c_rt;      N22_im = -r1 * s_rt;

        // Complex division: T = N / D = N * D_conj / |D|^2
        // D = denom_A − j·denom_B  →  D_conj = denom_A + j·denom_B
        // Re{N·D_conj} = N_re·A − N_im·(−B) = ... wait:
        //   (N_re+jN_im)(A+jB) = (N_re·A − N_im·B) + j(N_im·A + N_re·B)
        // So: Re{N/D} = (N_re·A − N_im·B) / |D|²
        //     Im{N/D} = (N_im·A + N_re·B) / |D|²
        T11_re = (N11_re * denom_A - N11_im * denom_B) / denom_sq;
        T11_im = (N11_im * denom_A + N11_re * denom_B) / denom_sq;
        T12_re = (N12_re * denom_A - N12_im * denom_B) / denom_sq;
        T12_im = (N12_im * denom_A + N12_re * denom_B) / denom_sq;
        T22_re = (N22_re * denom_A - N22_im * denom_B) / denom_sq;
        T22_im = (N22_im * denom_A + N22_re * denom_B) / denom_sq;

        // Read input fields
        E_in_re = Ophase(in_re);
        E_in_im = Ophase(in_im);
        E_ad_re = Ophase(ad_re);
        E_ad_im = Ophase(ad_im);

        // Superposition: E_th = T11·E_in + T12·E_ad
        //                E_dp = T12·E_in + T22·E_ad
        E_th_re = T11_re * E_in_re - T11_im * E_in_im
                + T12_re * E_ad_re - T12_im * E_ad_im;
        E_th_im = T11_im * E_in_re + T11_re * E_in_im
                + T12_im * E_ad_re + T12_re * E_ad_im;

        E_dp_re = T12_re * E_in_re - T12_im * E_in_im
                + T22_re * E_ad_re - T22_im * E_ad_im;
        E_dp_im = T12_im * E_in_re + T12_re * E_in_im
                + T22_im * E_ad_re + T22_re * E_ad_im;

        // Norton drive for output ports
        Oamp(th_re) <+ G_drv * (E_th_re - Ophase(th_re));
        Oamp(th_im) <+ G_drv * (E_th_im - Ophase(th_im));
        Oamp(dp_re) <+ G_drv * (E_dp_re - Ophase(dp_re));
        Oamp(dp_im) <+ G_drv * (E_dp_im - Ophase(dp_im));

        // High-impedance shunts on input (in and add) amplitude and lambda ports
        Oamp(in_re)     <+ 1e-12 * (-Ophase(in_re));
        Oamp(in_im)     <+ 1e-12 * (-Ophase(in_im));
        Oamp(in_lambda) <+ 1e-12 * (-Ophase(in_lambda));
        Oamp(ad_re)     <+ 1e-12 * (-Ophase(ad_re));
        Oamp(ad_im)     <+ 1e-12 * (-Ophase(ad_im));
        Oamp(ad_lambda) <+ 1e-12 * (-Ophase(ad_lambda));

        // Lambda: output ports follow input lambda
        Oamp(th_lambda) <+ G_drv * (Ophase(in_lambda) - Ophase(th_lambda));
        Oamp(dp_lambda) <+ G_drv * (Ophase(in_lambda) - Ophase(dp_lambda));

        // PN junction (L1): tiny leakage for node conditioning
        I(anode, cathode) <+ (V_pn - V_ref) * 1e-12;
    end
endmodule
