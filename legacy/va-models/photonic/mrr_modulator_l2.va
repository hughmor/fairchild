// MRR electro-optic modulator — Level 2 (Soref–Bennett plasma dispersion,
//                                         Shockley I–V, depletion Cj, FCA loss)
//
// Extends L1 with full PN junction physics in the same CMT framework.
// The round-trip phase and amplitude now depend nonlinearly on voltage:
//
//   ΔN(V)      = n_dep0 · (1 − sqrt(max(1 − V/Vbi, 0)))    (depletion charge)
//   Δn(ΔN)    = −8.8e-22·ΔN − 8.5e-18·ΔN^0.8              (Soref–Bennett, Si)
//   Δα_fc(ΔN)  = (8.5e-18 + 6.0e-18) · ΔN                  (FCA, cm⁻¹)
//
//   Δφ_PN = 2π·Δn·L_ring / λ
//   φ_rt  = 2π·n_g·L_ring/λ + Δφ_PN
//
//   Extra round-trip loss from FCA:
//     a_rt = exp(−(α_wg + Δα_fc)·L_ring)
//
//   Through-port: T = [(r−c)(1−rc)−rs²]/D + j[−sκ/D]   (unchanged CMT)
//
// Electrical port (L2):
//   I_diode = IS · (exp(V_pn/(n_id·Vt)) − 1)
//   I_cap   = ddt(Cj(V)·V_pn)
//
// Ports: same as mrr_modulator_l1 plus (implicitly) heavier junction physics
//
// Parameters:
//   kappa_0, L_ring_um, n_g, alpha_dB_cm — ring geometry / coupling
//   n_dep0      — free-carrier density at V=0 (cm⁻³); ~1e16–1e18 for Si
//   Vbi         — built-in potential (V)
//   mj          — grading coefficient (0.5 = abrupt)
//   Cj0         — zero-bias junction capacitance (F)
//   IS          — diode saturation current (A)
//   n_id        — ideality factor
//   wavelength_nm — design wavelength (nm); NR bootstrap

`include "disciplines.vams"
`include "constants.vams"
`include "disciplines/optical.vams"

module mrr_modulator_l2(in_re, in_im, in_lambda,
                         out_re, out_im, out_lambda,
                         anode, cathode);
    inout in_re, in_im, in_lambda;
    inout out_re, out_im, out_lambda;
    inout anode, cathode;
    optical    in_re, in_im, in_lambda, out_re, out_im, out_lambda;
    electrical anode, cathode;

    parameter real kappa_0      = 0.1    from [0:1];
    parameter real L_ring_um    = 100.0  from (0:inf);
    parameter real n_g          = 4.2    from (0:inf);
    parameter real alpha_dB_cm  = 2.0    from [0:inf);
    parameter real n_dep0       = 5e16   from (0:inf);  // cm⁻³
    parameter real Vbi          = 1.0    from (0:inf);
    parameter real mj           = 0.5    from (0:1];
    parameter real Cj0          = 50e-15 from (0:inf);  // F
    parameter real IS           = 1e-14  from (0:inf);
    parameter real n_id         = 1.5;
    parameter real wavelength_nm = 1550.0 from (0:inf);

    real wl_nm, V_pn, V_cj, dN, dn_opt, dalpha_fc;
    real phi_rt, dphi_pn, a_rt, r, kappa;
    real alpha_lin, alpha_total, c, s, denom_sq, T_re, T_im;
    real E_in_re, E_in_im, E_out_re, E_out_im;
    real Cj, Vt, tmp, G_drv;

    analog begin
        G_drv = 1.0e6;
        Vt    = `P_K * 300.0 / `P_Q;

        wl_nm = Ophase(in_lambda) * 1e3;
        if (wl_nm < wavelength_nm * 0.99) wl_nm = wavelength_nm;

        phi_rt = 2.0 * `M_PI * n_g * (L_ring_um * 1e-6) / (wl_nm * 1e-9);

        V_pn = V(anode, cathode);

        // Carrier depletion density
        tmp = 1.0 - V_pn / Vbi;
        if (tmp < 0.0) tmp = 0.0;
        dN = n_dep0 * (1.0 - sqrt(tmp));

        // Soref–Bennett plasma dispersion (signed pow handles depletion dN < 0)
        dn_opt    = -8.8e-22 * dN - 8.5e-18 * (dN >= 0.0 ? pow(dN, 0.8) : -pow(-dN, 0.8));
        dalpha_fc = (8.5e-18 + 6.0e-18) * dN;   // cm⁻¹

        dphi_pn = 2.0 * `M_PI * dn_opt * (L_ring_um * 1e-6) / (wl_nm * 1e-9);
        phi_rt  = phi_rt + dphi_pn;

        // Round-trip amplitude with FCA
        alpha_lin   = alpha_dB_cm * 1e2 / 8.685889;
        alpha_total = alpha_lin + dalpha_fc * 1e2;   // both in Np/m
        a_rt = exp(-alpha_total * (L_ring_um * 1e-6));

        kappa = kappa_0;
        r     = sqrt(1.0 - kappa);

        c        = a_rt * cos(phi_rt);
        s        = a_rt * sin(phi_rt);
        denom_sq = 1.0 - 2.0 * r * c + r * r * a_rt * a_rt;

        T_re = ((r - c) * (1.0 - r * c) + r * s * s) / denom_sq;
        T_im = -s * kappa / denom_sq;

        E_in_re = Ophase(in_re);
        E_in_im = Ophase(in_im);

        E_out_re = T_re * E_in_re - T_im * E_in_im;
        E_out_im = T_re * E_in_im + T_im * E_in_re;

        Oamp(out_re) <+ G_drv * (E_out_re - Ophase(out_re));
        Oamp(out_im) <+ G_drv * (E_out_im - Ophase(out_im));

        Oamp(in_re)     <+ 1e-12 * (-Ophase(in_re));
        Oamp(in_im)     <+ 1e-12 * (-Ophase(in_im));
        Oamp(in_lambda) <+ 1e-12 * (-Ophase(in_lambda));

        Oamp(out_lambda) <+ G_drv * (Ophase(in_lambda) - Ophase(out_lambda));

        // Shockley diode
        I(anode, cathode) <+ IS * (exp(V_pn / (n_id * Vt)) - 1.0);

        // Depletion capacitance
        V_cj = V_pn;
        if (V_cj > 0.99 * Vbi) V_cj = 0.99 * Vbi;
        Cj = Cj0 / pow(1.0 - V_cj / Vbi, mj);
        I(anode, cathode) <+ ddt(Cj * V_pn);
    end
endmodule
