// Straight optical waveguide — propagation loss + phase shift.
//
// B1 reference model: uses the new potential-only optical disciplines
// (`optical_field` for re/im, `optical_lambda` for wavelength) and stamps
// outputs via direct potential contributions.  No Norton hack.
//
// 3-wire port convention (single channel, forward-only):
//   in_re, in_im, in_lambda  — input field and wavelength
//   out_re, out_im, out_lambda — output field and wavelength
//
// Physics:  A_out = A_in · exp(-α·L/2) · exp(-j·β·L)
//           β = 2π·n_g / λ           (rad/m)
//
// Parameters:
//   L_um          — waveguide length in micrometres
//   n_g           — group index
//   alpha_dB_cm   — propagation loss in dB/cm
//   wavelength_nm — design wavelength (nm); used as NR bootstrap when the
//                   lambda wire hasn't been driven yet (Owl < 1 nm).

`include "constants.vams"
`include "disciplines.vams"
`include "disciplines/optical.vams"

module waveguide(in_re, in_im, in_lambda, out_re, out_im, out_lambda);
    inout in_re, in_im, in_lambda, out_re, out_im, out_lambda;
    optical_field  in_re, in_im, out_re, out_im;
    optical_lambda in_lambda, out_lambda;

    parameter real L_um          = 100.0  from (0:inf);
    parameter real n_g           = 4.2    from (0:inf);
    parameter real alpha_dB_cm   = 2.0    from [0:inf);
    parameter real wavelength_nm = 1550.0 from (0:inf);

    real wl_m, beta, phi_prop, alpha_lin, T_amp;
    real target_re, target_im;

    analog begin
        // Read wavelength from the lambda port (stored in metres).  Bootstrap
        // guard: when the upstream net hasn't been driven yet (early NR
        // iterations from x0 = 0), fall back to the design wavelength.
        wl_m = OWL(in_lambda);
        if (wl_m < wavelength_nm * 1e-9 * 0.99) wl_m = wavelength_nm * 1e-9;

        beta     = 2.0 * `M_PI * n_g / wl_m;
        phi_prop = beta * (L_um * 1e-6);

        alpha_lin = alpha_dB_cm * 1e2 / 8.6859;
        T_amp     = exp(-alpha_lin * (L_um * 1e-6) / 2.0);

        target_re = T_amp * ( OF(in_re) * cos(phi_prop) + OF(in_im) * sin(phi_prop));
        target_im = T_amp * (-OF(in_re) * sin(phi_prop) + OF(in_im) * cos(phi_prop));

        // Direct potential contributions — no Norton hack.
        OF(out_re)     <+ target_re;
        OF(out_im)     <+ target_im;
        OWL(out_lambda) <+ OWL(in_lambda);
    end
endmodule
