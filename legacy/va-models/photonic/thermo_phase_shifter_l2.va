// Thermo-optic phase shifter — Level 2 (external temperature node, RC dynamics)
//
// Separates the thermo-optic effect from the thermal network.  The temperature
// rise ΔT is the voltage on an external node (T_node), allowing the user to
// attach any thermal circuit in the SPICE netlist:
//
//   Rth   T_node 0  Rth_value     ; thermal resistance (K/W → 1 Ω ≡ 1 K/W)
//   Cth   T_node 0  Cth_value     ; thermal capacitance (J/K → 1 F ≡ 1 J/K)
//
// This model injects the Joule power P_heat = V²/R_heater as a current into
// T_node.  With a simple series RC:
//   τ_thermal = R_thermal × C_thermal
//   ΔT_ss     = P_heat × R_thermal
//
// The split makes it easy to model multi-segment heaters, thermal crosstalk
// (coupled T_node networks), or substrate heat-spreading with a ladder network.
//
// Physics:
//   dT    = V(T_node, 0)          temperature rise (K)
//   Δφ    = 2π·(dn/dT)·dT·L / λ
//   phi   = phi_prop + Δφ
//
//   I(T_node, 0) = −P_heat = −V_heat²/R_heater   (current injection into T_node)
//   I(heat_p, heat_n) = V_heat / R_heater          (heater current)
//
// Ports:
//   in_re, in_im, in_lambda    — optical input
//   out_re, out_im, out_lambda — optical output
//   heat_p, heat_n             — heater electrical terminals
//   T_node                     — thermal node (V = ΔT in K; tie through Rth, Cth to GND)
//
// Parameters:
//   L_um        — waveguide length (µm)
//   n_g         — group index
//   alpha_dB_cm — propagation loss (dB/cm)
//   R_heater    — heater resistance (Ω)
//   dn_dT       — thermo-optic coefficient (K⁻¹); Si +1.86e-4, SiN +2.45e-5
//   wavelength_nm — design wavelength (nm)

`include "disciplines.vams"
`include "constants.vams"
`include "disciplines/optical.vams"

module thermo_phase_shifter_l2(in_re, in_im, in_lambda,
                                out_re, out_im, out_lambda,
                                heat_p, heat_n, T_node);
    inout in_re, in_im, in_lambda;
    inout out_re, out_im, out_lambda;
    inout heat_p, heat_n, T_node;
    optical    in_re, in_im, in_lambda, out_re, out_im, out_lambda;
    electrical heat_p, heat_n, T_node;

    parameter real L_um         = 100.0   from (0:inf);
    parameter real n_g          = 4.2     from (0:inf);
    parameter real alpha_dB_cm  = 2.5     from [0:inf);
    parameter real R_heater     = 1000.0  from (0:inf);   // Ω
    parameter real dn_dT        = 1.86e-4 from (0:inf);   // K⁻¹
    parameter real wavelength_nm = 1550.0 from (0:inf);

    real wl_nm, phi_prop, dphi_therm, phi_total;
    real alpha_lin, T_amp, G_drv;
    real E_in_re, E_in_im, E_out_re, E_out_im;
    real V_heat, P_heat, dT, dn;

    analog begin
        G_drv = 1.0e6;

        wl_nm = Ophase(in_lambda) * 1e3;
        if (wl_nm < wavelength_nm * 0.99) wl_nm = wavelength_nm;

        phi_prop = 2.0 * `M_PI * n_g * (L_um * 1e-6) / (wl_nm * 1e-9);

        // Temperature rise read from external thermal node
        // V(T_node) = voltage to implicit ground = ΔT in K
        dT   = V(T_node);
        dn   = dn_dT * dT;
        dphi_therm = 2.0 * `M_PI * dn * (L_um * 1e-6) / (wl_nm * 1e-9);

        phi_total = phi_prop + dphi_therm;

        alpha_lin = alpha_dB_cm * 1e2 / 8.685889;
        T_amp     = exp(-alpha_lin * (L_um * 1e-6) / 2.0);

        E_in_re = Ophase(in_re);
        E_in_im = Ophase(in_im);

        E_out_re = T_amp * ( E_in_re * cos(phi_total) + E_in_im * sin(phi_total));
        E_out_im = T_amp * (-E_in_re * sin(phi_total) + E_in_im * cos(phi_total));

        Oamp(out_re) <+ G_drv * (E_out_re - Ophase(out_re));
        Oamp(out_im) <+ G_drv * (E_out_im - Ophase(out_im));

        Oamp(in_re)     <+ 1e-12 * (-Ophase(in_re));
        Oamp(in_im)     <+ 1e-12 * (-Ophase(in_im));
        Oamp(in_lambda) <+ 1e-12 * (-Ophase(in_lambda));

        Oamp(out_lambda) <+ G_drv * (Ophase(in_lambda) - Ophase(out_lambda));

        // Heater current (Ohm's law)
        V_heat = V(heat_p, heat_n);
        I(heat_p, heat_n) <+ V_heat / R_heater;

        // Inject Joule power into thermal node.
        // I(T_node) <+ -P means P_heat flows from ground into T_node, raising V(T_node).
        // The external Rth/Cth network sets the DC and transient temperature.
        P_heat = V_heat * V_heat / R_heater;
        I(T_node) <+ -P_heat;
    end
endmodule
